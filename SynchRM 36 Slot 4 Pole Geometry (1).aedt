# Ansys Electronics Desktop project, version 2023.2
materials:
  vacuum: permittivity=1
  Nippon 27ZH100: CoordinateSystemType=Cylindrical permeability{HUnit=A_per_meter BUnit=tesla curve (0, 0) (1.00579, 0.0328892) (1.4968, 0.0575558) (1.97713, 0.0842779) (2.61167, 0.121278) (3.29672, 0.164444) (3.97669, 0.211721) (4.68931, 0.269276) (5.25411, 0.324775) (5.72211, 0.378219) (6.71064, 0.505661) (7.1443, 0.56116) (7.56304, 0.622826) (8.00637, 0.686547) (8.77123, 0.82221) (9.28572, 0.898264) (9.88682, 0.990763) (10.5265, 1.07093) (11.2718, 1.16754) (12.2078, 1.26209) (13.221, 1.34637) (14.6476, 1.43681) (16.3194, 1.50259) (18.3896, 1.56837) (20.9585, 1.62387) (24.159, 1.67732) (29.1425, 1.73077) (35.153, 1.77599) (43.1308, 1.813) (54.1349, 1.85002) (66.4182, 1.8747) (83.3606, 1.89939) (103.442, 1.91791) (136.635, 1.94056) (188.865, 1.95913) (264.044, 1.97978) (415.902, 2.00258) (622.453, 2.02134) (991.623, 2.03825) (1982.62, 2.06416) (4365.55, 2.07743) (10059.1, 2.08869) (16245, 2.0992) (26235, 2.1135) (42368, 2.1348) (68422, 2.1682) (110500, 2.2215)}
  copper: permeability=0.999991 conductivity=58000000

design Maxwell3DDesign1 (Maxwell 3D, Magnetostatic, model units mm)
geometry:
  CirPattern1 = imported_body(C:\Users\amsma\OneDrive\Desktop\Ansys Files\SynchRM 36 Slot 4 Pole.STEP)
  Mirror1 = imported_body(C:\Users\amsma\OneDrive\Desktop\Ansys Files\SynchRM Rotor w More Flux Guides- 4 poles.STEP)
  Mirror1_1, Mirror1_2, Mirror1_3 = Mirror1.duplicate_around_axis(axis=Y, angle=90deg, total=4)
  group SynchRM36Slot4Pole = CirPattern1
mesh:
  initial mesh: GlobalCurvilinear{Apply}

design Maxwell2DDesign1 (Maxwell 2D, Transient, XY geometry, model units mm)
options: ModelDepth=150mm
variables:
  turns = 0
geometry:
  Mirror4, Mirror4_1, Mirror4_2, Mirror4_3, CirPattern1 = imported_body(C:\Users\amsma\OneDrive\Desktop\Ansys Files\SynchRM 36 Slot 4 Pole.STEP)
  Rotor_iron_1 [Nippon 27ZH100] = Mirror4.section(plane=ZX)
  Mirror4.delete()
  Rotor_iron_1.rotate(axis=X, angle=-90deg)
  Rotor_iron [Nippon 27ZH100] = Mirror4_1.section(plane=ZX)
  Mirror4_1.delete()
  Rotor_iron.rotate(axis=X, angle=-90deg)
  Rotor_iron_2 [Nippon 27ZH100] = Mirror4_2.section(plane=ZX)
  Mirror4_2.delete()
  Rotor_iron_2.rotate(axis=X, angle=-90deg)
  Rotor_iron_3 [Nippon 27ZH100] = Mirror4_3.section(plane=ZX)
  Mirror4_3.delete()
  Rotor_iron_3.rotate(axis=X, angle=-90deg)
  Stator_Iron [Nippon 27ZH100] = CirPattern1.section(plane=ZX)
  CirPattern1.delete()
  Stator_Iron.rotate(axis=X, angle=-90deg)
  U_1_, V_1_ [copper] = imported_body()
  V_3, V_5 = imported_body()
  W_1_ [copper] = imported_body()
  W_5, W_4 = imported_body()
  U_2_ [copper] = imported_body()
  U_5, U_7 = imported_body()
  V_2_ [copper] = imported_body()
  V_7, V_8 = imported_body()
  W_2_ [copper] = imported_body()
  W_6, W_8, V_9, V_10, V_11, W_9, W_10, W_11, U_11, U_1, U_2, V_1, V_2, V, W, W_1, W_2 = imported_body()
  U_2_.unite(U_5, U_7, U_2, U_1, U_11)
  V_1_.unite(V_3, V_5, V_11, V_10, V_9)
  V_2_.unite(V_7, V_8, V, V_2, V_1)
  W_1_.unite(W_5, W_4, W_11, W_10, W_9)
  W_2_.unite(W_8, W_6, W_2, W_1, W)
  Inner_Region [vacuum] = circle(normal=Z, centre=(0mm, 0mm, 0mm), radius=70mm)
  Band [vacuum] = circle(normal=Z, centre=(0mm, 0mm, 0mm), radius=70.25mm)
  Outer_Region [vacuum] = circle(normal=Z, centre=(0mm, 0mm, 0mm), radius=115mm)
  U_1__Separate1..U_1__Separate5 = U_1_.separate_bodies()
  U_1_.unite(U_1__Separate1..U_1__Separate5)
  group SynchRM36Slot4Pole = Rotor_iron_1, Rotor_iron, Rotor_iron_2, Rotor_iron_3, Stator_Iron
boundaries and excitations:
  U_1_in: Coil Objects=U_1_ Conductor_number=turns Winding=U PolarityType=Negative
  U_2_out: Coil Objects=U_2_ Conductor_number=turns Winding=U PolarityType=Positive
  V_1_out: Coil Objects=V_1_ Conductor_number=turns Winding=V PolarityType=Positive
  V_2_in: Coil Objects=V_2_ Conductor_number=turns Winding=V PolarityType=Negative
  W_1_in: Coil Objects=W_1_ Conductor_number=turns Winding=W PolarityType=Negative
  W_2_out: Coil Objects=W_2_ Conductor_number=turns Winding=W PolarityType=Positive
  U: Winding Group Type=Current IsSolid=false Current=0 ParallelBranchesNum=1
  V: Winding Group Type=Current IsSolid=false Current=0 ParallelBranchesNum=1
  W: Winding Group Type=Current IsSolid=false Current=0 ParallelBranchesNum=1
mesh:
  CylindricalGap1: CylindricalGap Objects=Band Objects=Band
  Iron: LengthBased Objects=[Rotor_iron, Rotor_iron_1, Rotor_iron_2, Rotor_iron_3, Stator_Iron] MaxLength=6mm
  Copper: LengthBased Objects=[U_1_, U_2_, V_1_, V_2_, W_1_, W_2_] MaxLength=3mm
